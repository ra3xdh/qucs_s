.SUBCKT XFMR P1 P2 S1 S2 RATIO=1
R1 0 _net0  1E9 tc1=0.0 tc2=0.0
GSRC3 S2 S1 _net0 0 1
GSRC4 _net0 0 S1 S2 1
GSRC1 0 _net0 P1 P2 {1.0/RATIO}
GSRC2 P1 P2 _net0 0 {1.0/RATIO}
.ENDS
